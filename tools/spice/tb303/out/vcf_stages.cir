* TB-303 VCF ac, k=0.0 itail=3e-05 gfb=None

* Generic small-signal NPN for every transistor (2SC1583 pairs Q12/Q21,
* 2SC2291 pair Q22, ladder and buffer transistors). NOT vendor models.
.model QN NPN(IS=1e-14 BF=300 VAF=100 CJE=8p CJC=4p TF=0.4n RB=50)

VCC vcc 0 12
VREF vref 0 5.333
* --- filter rail: R95 100 ohm, C28 47u
R95 vcc vtop 100
C28 vtop 0 47u
* --- Q22 top pair, bases through R115 10k (C30 decoupling, value unread: 10u)
R115 vtop b22 10k
C30 b22 0 10u
Q22L vtop b22 dL QN
Q22R vtop b22 dR QN
* --- diode-connected ladder (base = collector) and its capacitors
Q16 dL dL cL QN
Q23 dR dR cR QN
Q14 cL cL bL QN
Q17 cR cR bR QN
Q13 bL bL aL QN
Q15 bR bR aR QN
C26 dL dR 0.033u
C24 cL cR 0.033u
C19 bL bR 0.033u
C18 aL aR 0.018u
* --- Q12 input pair; tail = Q11 collector (ideal here)
Q12L aL inL tail QN
Q12R aR inR tail QN
ITAIL tail 0 3.000000e-05
* --- input: S1 -> R62 220k -> C17 1u -> Q12L base; R70/R98 2.2k to the bias
*     node nb (R68 2.2k from the 5.333 V reference, C16 10u)
R62 s1 n62 220k
C17 n62 inL 1u
R70 inL nb 2.2k
R98 inR nb 2.2k
R68 vref nb 2.2k
C16 nb 0 10u
* --- output: C27/C25 0.1u across the top capacitor into the Q21 pair
* as drawn, the coupling capacitors cross: C27 takes the right top node to
* Q21's left base, C25 the left top node to its right base
C27 dR b21L 0.1u
C25 dL b21R 0.1u
R113 b21L nb21 100k
R114 b21R nb21 100k
R116 vref nb21 10k
C29 nb21 0 1u
Q21L c21L b21L t21 QN
Q21R c21R b21R t21 QN
R111 vtop c21L 2.2k
R110 vtop c21R 2.2k
Q20 t21 b20 e20 QN
R112 nb21 b20 10k
R109 b20 0 10k
R108 e20 0 2.2k
Q19 vtop c21R out19 QN
R96 out19 0 10k
C14 out19 fout 1u
* --- resonance: VR4 50k (B) from the output to ground, wiper -> C15
RVRT fout wip 50000.000
RVRB wip 0 1.000
C15 wip n15 1u
R67 n15 b18 2.2k
R99 b18 nb18 100k
R66 vref nb18 100k
C22 nb18 0 1u
Q18 vcc b18 q18e QN
R94 q18e 0 10k
C23 q18e n23 1u
R97 n23 inR 10k
* --- VCA input load (IC15 path, R121 220k / C21; approximated)
RVCA fout 0 220k
VIN s1 0 DC 8.5 AC 1

.options reltol=1e-4
.ac dec 60 5 22k
.control
run
wrdata vcf_stages.txt v(dL,dR) v(inL,inR) v(b21L,b21R) v(c21R) v(fout)
quit
.endc
.end
